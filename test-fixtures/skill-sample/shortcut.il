;; shortcut.il - A simple skill with no dependencies

procedure(saveView(
  let((viewName)
    printf("View saved\n")
  )
))

procedure(restoreView(
  let((viewName)
    printf("View restored\n")
  )
))
