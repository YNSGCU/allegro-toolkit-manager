;; company_skill.il - Simulates a company read-only skill

procedure(companyInit(
  printf("Company skill loaded\n")
))

procedure(checkLicense(
  printf("License checked\n")
))
